ADE simulation setup
Test Lab2_Decoder_D1_TB_1: Lab2/Decoder_D1_TB/schematic, simulator spectre
  Models: /home/viterbi/01/ee577/CDS_GPDK45/gpdk045_v_5_0/gpdk045/../models/spectre/gpdk045.scs[mc]
  Variables: CapOut = 6.4f; transition = 40p
  Temperature: 27
  Stimulus VSS!: voltage dc dc=0
  Stimulus VDD!: voltage dc dc=1
  Stimulus A_in: voltage bit period=1n data=00
  Stimulus B_in: voltage bit period=1n data=00
  Stimulus C_in: voltage bit period=1n data=00
  Stimulus D_in: voltage bit period=1n data=10
  Analysis tran: stop=2n
  Output delay(?wf1 VT("/D") ?value1 0.5 ?edge1 "falling" ?nth1 1 ?td1 0.0 ?tol1 nil ?wf2 VT("/W0") ?value2 0.5 ?edge2 "rising" ?nth2 1 ?tol2 nil ?td2 nil ?stop nil ?multiple nil)
  Signals: /A, /B, /C, /D, /W0
Run mode: Single Run, Sweeps and Corners
