ADE simulation setup
Test Lab2_Timing_1: Lab2/Timing/schematic, simulator spectre
  Models: /home/viterbi/01/ee577/CDS_GPDK45/gpdk045_v_5_0/gpdk045/../models/spectre/gpdk045.scs[mc]
  Variables: transition = 40p; Cout = 0.1f
  Temperature: 27
  Stimulus B_bar: voltage bit val1=1 val0=0 period=1n data=00100001
  Stimulus VDD!: voltage dc dc=1
  Stimulus A_Bar: voltage bit val1=1 val0=0 period=1n data=10000100
  Stimulus VSS!: voltage dc dc=0
  Analysis tran: stop=20n
  Output AfallTime = fallTime(VT("/A") 0 nil 0 nil 10 90 nil "time")
  Output AriseTime = riseTime(VT("/A") 0 nil 0 nil 10 90 nil "time")
  Output AY_cellFall = delay(?wf1 VT("/A") ?value1 0.5 ?edge1 "rising" ?nth1 1 ?td1 0.0 ?tol1 nil ?wf2 VT("/Y") ?value2 0.5 ?edge2 "falling" ?nth2 1 ?tol2 nil ?td2 nil ?stop nil ?multiple nil)
  Output AY_cellRise = delay(?wf1 VT("/A") ?value1 0.5 ?edge1 "falling" ?nth1 1 ?td1 0.0 ?tol1 nil ?wf2 VT("/Y") ?value2 0.5 ?edge2 "rising" ?nth2 2 ?tol2 nil ?td2 nil ?stop nil ?multiple nil)
  Output AY_fallTransistion = delay(?wf1 VT("/Y") ?value1 0.9 ?edge1 "falling" ?nth1 1 ?td1 0.0 ?tol1 nil ?wf2 VT("/Y") ?value2 0.1 ?edge2 "falling" ?nth2 1 ?tol2 nil ?td2 nil ?stop nil ?multiple nil)
  Output AY_riseTransistion = delay(?wf1 VT("/Y") ?value1 0.1 ?edge1 "rising" ?nth1 1 ?td1 0.0 ?tol1 nil ?wf2 VT("/Y") ?value2 0.9 ?edge2 "rising" ?nth2 1 ?tol2 nil ?td2 nil ?stop nil ?multiple nil)
  Output BfallTime = fallTime(VT("/B") 0 nil 0 nil 10 90 nil "time")
  Output BriseTime = riseTime(VT("/B") 0 nil 0 nil 10 90 nil "time")
  Output BY_cellFall = delay(?wf1 VT("/B") ?value1 0.5 ?edge1 "rising" ?nth1 1 ?td1 0.0 ?tol1 nil ?wf2 VT("/Y") ?value2 0.5 ?edge2 "falling" ?nth2 2 ?tol2 nil ?td2 nil ?stop nil ?multiple nil)
  Output BY_cellRise = delay(?wf1 VT("/B") ?value1 0.5 ?edge1 "falling" ?nth1 1 ?td1 0.0 ?tol1 nil ?wf2 VT("/Y") ?value2 0.5 ?edge2 "rising" ?nth2 1 ?tol2 nil ?td2 nil ?stop nil ?multiple nil)
  Output BY_fallTransistion = delay(?wf1 VT("/Y") ?value1 0.9 ?edge1 "falling" ?nth1 1 ?td1 0.0 ?tol1 nil ?wf2 VT("/Y") ?value2 0.1 ?edge2 "falling" ?nth2 1 ?tol2 nil ?td2 nil ?stop nil ?multiple nil)
  Output BY_riseTransistion = delay(?wf1 VT("/Y") ?value1 0.1 ?edge1 "rising" ?nth1 1 ?td1 0.0 ?tol1 nil ?wf2 VT("/Y") ?value2 0.9 ?edge2 "rising" ?nth2 1 ?tol2 nil ?td2 nil ?stop nil ?multiple nil)
  Signals: /A, /B, /Y
Run mode: Single Run, Sweeps and Corners
Setup values for test Lab2_Timing_1: Cout = {Inclusion List}0.1f{Inclusion List}{From/To}Auto:0.1f:20:1f{From/To}
