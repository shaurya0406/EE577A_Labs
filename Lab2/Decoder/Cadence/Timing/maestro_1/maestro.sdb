ADE simulation setup
Run mode: Single Run, Sweeps and Corners
Tests:
  Lab2_Timing_1: Lab2/Timing/schematic, simulator spectre
    Variables: Cout = {Inclusion List}0.1f{Inclusion List}{From/To}Auto:0.1f:20:1f{From/To}; transition = 40p
    Outputs: /A; /B; /Y; AfallTime; AriseTime; AY_cellFall; AY_cellRise; AY_fallTransistion; AY_riseTransistion; BfallTime; BriseTime; BY_cellFall; BY_cellRise; BY_fallTransistion; BY_riseTransistion
