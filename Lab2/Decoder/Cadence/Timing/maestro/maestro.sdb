ADE simulation setup
Run mode: Single Run, Sweeps and Corners
Tests:
  Lab2_Timing_1: Lab2/Timing/schematic, simulator spectre
    Variables: Cout = 0.1f; transition = 40p
    Outputs: /A; /B; /Y; AfallTime; AriseTime; AY_cellFall; AY_cellRise; AY_fallTransistion; AY_riseTransistion; BfallTime; BriseTime; BY_cellFall; BY_cellRise; BY_fallTransistion; BY_riseTransistion
