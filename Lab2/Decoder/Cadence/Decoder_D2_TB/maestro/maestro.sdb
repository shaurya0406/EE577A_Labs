ADE simulation setup
Run mode: Single Run, Sweeps and Corners
Tests:
  Lab2_Decoder_D2_TB_1: Lab2/Decoder_D2_TB/schematic, simulator spectre
    Variables: CapOut = 6.4f; transition = 40p
    Outputs: /A; /B; /C; /D; /W0; /W1; /W2; /W3; /W4; /W5; /W6; /W7; /W8; /W9; /W10; /W11; /W12; /W13; /W14; /W15
