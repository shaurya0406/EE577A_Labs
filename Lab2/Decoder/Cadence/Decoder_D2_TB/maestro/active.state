ADE simulation setup
Test Lab2_Decoder_D2_TB_1: Lab2/Decoder_D2_TB/schematic, simulator spectre
  Models: /home/viterbi/01/ee577/CDS_GPDK45/gpdk045_v_5_0/gpdk045/../models/spectre/gpdk045.scs[mc]
  Variables: CapOut = 6.4f; transition = 40p
  Temperature: 27
  Stimulus VDD!: voltage dc dc=1
  Stimulus VSS!: voltage dc dc=0
  Stimulus A_in: voltage bit period=1n data=0000000011111111
  Stimulus B_in: voltage bit period=1n data=0000111100001111
  Stimulus C_in: voltage bit period=1n data=0011001100110011
  Stimulus D_in: voltage bit period=1n data=0101010101010101
  Analysis tran: stop=20n
  Signals: /A, /B, /C, /D, /W0, /W1, /W2, /W3, /W4, /W5, /W6, /W7, /W8, /W9, /W10, /W11, /W12, /W13, /W14, /W15
Run mode: Single Run, Sweeps and Corners
