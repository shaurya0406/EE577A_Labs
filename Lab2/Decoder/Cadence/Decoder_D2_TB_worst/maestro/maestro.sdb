ADE simulation setup
Run mode: Single Run, Sweeps and Corners
Tests:
  Lab2_Decoder_D2_TB_1: Lab2/Decoder_D2_TB/schematic, simulator spectre
    Variables: CapOut = 6.4f; transition = 40p
    Outputs: "/A"; /A; /B; /C; /D; /W0; delay(?wf1 VT("/B") ?value1 0.5 ?edge1 "rising" ?nth1 1 ?td1 0.0 ?tol1 nil ?wf2 VT("/W0") ?value2 0.5 ?edge2 "falling" ?nth2 1 ?tol2 nil ?td2 nil ?stop nil ?multiple nil); delay(?wf1 VT("/B") ?value1 0.5 ?edge1 "falling" ?nth1 1 ?td1 0.0 ?tol1 nil ?wf2 VT("/W0") ?value2 0.5 ?edge2 "rising" ?nth2 1 ?tol2 nil ?td2 nil ?stop nil ?multiple nil); delay(?wf1 VT("/C") ?value1 0.5 ?edge1 "falling" ?nth1 1 ?td1 0.0 ?tol1 nil ?wf2 VT("/W0") ?value2 0.5 ?edge2 "rising" ?nth2 1 ?tol2 nil ?td2 nil ?stop nil ?multiple nil)
