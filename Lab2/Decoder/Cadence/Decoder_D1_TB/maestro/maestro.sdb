ADE simulation setup
Run mode: Single Run, Sweeps and Corners
Tests:
  Lab2_Decoder_D1_TB_1: Lab2/Decoder_D1_TB/schematic, simulator spectre
    Variables: CapOut = 6.4f; transition = 40p
    Outputs: /A; /B
