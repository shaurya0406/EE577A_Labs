ADE simulation setup
Test Lab2_Decoder_D1_TB_1: Lab2/Decoder_D1_TB/schematic, simulator spectre
  Models: /home/viterbi/01/ee577/CDS_GPDK45/gpdk045_v_5_0/gpdk045/../models/spectre/gpdk045.scs[mc]
  Variables: transition = 40p; CapOut = 6.4f
  Temperature: 27
  Stimulus VSS!: voltage dc dc=0
  Stimulus VDD!: voltage dc dc=1
  Stimulus A_in: voltage bit period=1n data=000011110
  Stimulus B_in: voltage bit period=1n data=000111100
  Stimulus C_in: voltage bit period=1n data=001111000
  Stimulus D_in: voltage bit period=1n data=011110000
  Analysis tran: stop=20n
  Signals: /A, /B
Run mode: Single Run, Sweeps and Corners
