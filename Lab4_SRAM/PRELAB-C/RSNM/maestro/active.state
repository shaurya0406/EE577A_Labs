ADE simulation setup
Test PRELAB-C_RSNM_1: PRELAB-C/RSNM/schematic, simulator spectre
  Models: /home/viterbi/01/ee577/CDS_GPDK45/gpdk045_v_5_0/gpdk045/../models/spectre/gpdk045.scs[mc]
  Temperature: 27
  Stimulus vdd!: voltage dc dc=1
  Stimulus BLB: voltage dc dc=1
  Stimulus BL: voltage dc dc=1
  Stimulus WL: voltage dc dc=1
  Analysis dc: sweep /V0.dc start=0 stop=1 (saves the operating point)
Run mode: Single Run, Sweeps and Corners
