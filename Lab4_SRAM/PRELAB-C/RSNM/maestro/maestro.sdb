ADE simulation setup
Run mode: Single Run, Sweeps and Corners
Tests:
  PRELAB-C_RSNM_1: PRELAB-C/RSNM/schematic, simulator spectre
    Outputs: /Q; /QB
