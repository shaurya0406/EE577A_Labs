ADE simulation setup
Test PRELAB-C_SRAM_Bank1_TB_1: PRELAB-C/SRAM_Bank1_TB_v2_power/config, simulator spectre
  Models: /home/viterbi/01/ee577/CDS_GPDK45/gpdk045_v_5_0/gpdk045/../models/spectre/gpdk045.scs[mc]
  Temperature: 27
  Files: vectors /home/viterbi/04/shauryac/work_gpdk045/PRELAB-C/SRAM_1Bank_Layout_Test.vec
  Stimulus CLK: voltage pulse dc=1 val0=0 val1=1 period=1n delay=0 rise=5p fall=5p
  Analysis tran: stop=60n
  Output ADDR_IN_HEX = awvCreateBus("ADDR_IN_HEX" list(awvAnalog2Digital(VT("/A<4>") nil nil 0.5 nil "centre") awvAnalog2Digital(VT("/A<3>") nil nil 0.5 nil "centre") awvAnalog2Digital(VT("/A<2>") nil nil 0.5 nil "centre") awvAnalog2Digital(VT("/A<1>") nil nil 0.5 nil "centre") awvAnalog2Digital(VT("/A<0>") nil nil 0.5 nil "centre")) "Hex")
  Output ADDR_OUT_HEX = awvCreateBus("ADDR_OUT_HEX" list(awvAnalog2Digital(VT("/A_out<4>") nil nil 0.5 nil "centre") awvAnalog2Digital(VT("/A_out<3>") nil nil 0.5 nil "centre") awvAnalog2Digital(VT("/A_out<2>") nil nil 0.5 nil "centre") awvAnalog2Digital(VT("/A_out<1>") nil nil 0.5 nil "centre") awvAnalog2Digital(VT("/A_out<0>") nil nil 0.5 nil "centre")) "Hex")
  Output DATA_IN_HEX = awvCreateBus("DATA_IN_HEX" list(awvAnalog2Digital(VT("/data<3>") nil nil 0.5 nil "centre") awvAnalog2Digital(VT("/data<2>") nil nil 0.5 nil "centre") awvAnalog2Digital(VT("/data<1>") nil nil 0.5 nil "centre") awvAnalog2Digital(VT("/data<0>") nil nil 0.5 nil "centre")) "Hex")
  Output DATA_HEX = awvCreateBus("DATA_HEX" list(awvAnalog2Digital(VT("/data<3>") nil nil 0.5 nil "centre") awvAnalog2Digital(VT("/data<2>") nil nil 0.5 nil "centre") awvAnalog2Digital(VT("/data<1>") nil nil 0.5 nil "centre") awvAnalog2Digital(VT("/data<0>") nil nil 0.5 nil "centre")) "Hex")
  Output AVG_WRITE_CURRENT = average(abs(clip(IT("/V0/PLUS") 3e-09 5e-09)))
  Output DATA_OUT_HEX = awvCreateBus("DATA_OUT_HEX" list(awvAnalog2Digital(VT("/data_out<3>") nil nil 0.5 nil "centre") awvAnalog2Digital(VT("/data_out<2>") nil nil 0.5 nil "centre") awvAnalog2Digital(VT("/data_out<1>") nil nil 0.5 nil "centre") awvAnalog2Digital(VT("/data_out<0>") nil nil 0.5 nil "centre")) "Hex") (unticked)
  Output AVG_READ_CURRENT = average(abs(clip(IT("/V0/PLUS") 3.3e-08 3.4e-08)))
  Output AVG_LEAKAGE_CURRENT = average(abs(clip(IT("/V0/PLUS") 0.0 2e-09)))
  Signals: /CLK, /precharge_en, /A<4:0>, /A_out<4:0>, /data<3:0>, /write_en, /decoder_en, /W<7:0>, /WL<7:0>, /WL<0>, /pre_en_SA, /read_en, /sense_en, /data_out<3:0>, /V0/PLUS (terminal), /I4/A<1> (terminal), /I4/precharge_en (terminal)
Run mode: Single Run, Sweeps and Corners
