ADE simulation setup
Run mode: Single Run, Sweeps and Corners
Tests:
  PRELAB-C_SRAM_Bank1_TB_1: PRELAB-C/SRAM_Bank1_TB_v2_power/config, simulator spectre
    Outputs: /CLK; /precharge_en; /A<4:0>; /A_out<4:0>; /data<3:0>; /write_en; /decoder_en; /WL<0>; /BL<15:0>; /BLB<15:0>; /pre_en_SA; /read_en; /sense_en; /data_out<3:0>; /WL<7:0>; /W<7:0>; AVG_WRITE_CURRENT; AVG_READ_CURRENT
