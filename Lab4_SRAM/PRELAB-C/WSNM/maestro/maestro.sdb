ADE simulation setup
Run mode: Single Run, Sweeps and Corners
Tests:
  PRELAB-C_WSNM_1: PRELAB-C/WSNM/schematic, simulator spectre
    Outputs: /QB1; /Vswp; /Q2
