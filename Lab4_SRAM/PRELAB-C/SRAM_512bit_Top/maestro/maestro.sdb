ADE simulation setup
Run mode: Single Run, Sweeps and Corners
Tests:
  PRELAB-C_SRAM_512bit_Top_1: PRELAB-C/SRAM_512bit_Top/schematic, simulator spectre
    Outputs: /CLK; /A<4:0>; /A_out<4:0>; /data<15:0>; /data_out<15:0>; /precharge_en; /write_en; /decoder_en; /WL<7:0>; /EN<3:0>; /BL<15:0>; /BLB<15:0>; /pre_en_SA; /read_en; /sense_en; /I1/I<7>/I<0>/Q; /I1/I<7>/I<0>/QB
