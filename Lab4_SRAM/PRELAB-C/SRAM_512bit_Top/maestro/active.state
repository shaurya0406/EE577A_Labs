ADE simulation setup
Test PRELAB-C_SRAM_512bit_Top_1: PRELAB-C/SRAM_512bit_Top/schematic, simulator spectre
  Models: /home/viterbi/01/ee577/CDS_GPDK45/gpdk045_v_5_0/gpdk045/../models/spectre/gpdk045.scs[mc]
  Temperature: 27
  Files: vectors /home/viterbi/04/shauryac/work_gpdk045/PRELAB-C/SRAM_512_Test.vec
  Stimulus CLK: voltage pulse dc=0 val0=0 val1=1 period=1n delay=0 rise=5p fall=5p
  Stimulus vdd!: voltage dc dc=1
  Analysis tran: stop=55n
  Signals: /CLK, /A<4:0>, /A_out<4:0>, /data<15:0>, /data_out<15:0>, /precharge_en, /write_en, /decoder_en, /WL<7:0>, /pre_en_SA, /read_en, /sense_en
Run mode: Single Run, Sweeps and Corners
