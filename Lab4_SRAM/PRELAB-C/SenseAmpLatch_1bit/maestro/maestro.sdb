ADE simulation setup
Run mode: Single Run, Sweeps and Corners
Tests:
  PRELAB-C_SenseAmpLatch_1bit_1: PRELAB-C/SenseAmpLatch_1bit/schematic, simulator spectre
    Outputs: /BL; /precharge_en_SA; /read_en; /sense_en; /net6; /net7; /net8; /data_out; /clk; /OUT; /OUTB; /DATA
