ADE simulation setup
Test PRELAB-C_SenseAmpLatch_1bit_1: PRELAB-C/SenseAmpLatch_1bit/schematic, simulator spectre
  Models: /home/viterbi/01/ee577/CDS_GPDK45/gpdk045_v_5_0/gpdk045/../models/spectre/gpdk045.scs[mc]
  Temperature: 27
  Stimulus vdd!: voltage dc dc=1
  Stimulus BL: voltage pulse dc=1 val0=1 val1=900.0m period=2n delay=200.0p rise=1n fall=300.0p width=0
  Stimulus BLB: voltage dc dc=1
  Stimulus precharge_en_SA: voltage pulse dc=1 val0=0 val1=1 period=2n delay=200.0p rise=5p fall=5p width=1n
  Stimulus read_en: voltage pulse dc=1 val0=1 val1=0 period=2n delay=200.0p rise=5p fall=5p width=1n
  Stimulus sense_en: voltage pulse dc=1 val0=0 val1=1 period=2n delay=1.2n rise=5p fall=5p width=500.0p
  Stimulus clk: voltage pulse dc=1 val0=1 val1=0 period=2n delay=500.0p rise=5p fall=5p width=1n
  Initial conditions: /data_out = 1; /DATA = 1
  Analysis tran: stop=2.5n
  Signals: /BL, /precharge_en_SA, /read_en, /sense_en, /OUT, /OUTB, /DATA, /data_out, /clk
Run mode: Single Run, Sweeps and Corners
