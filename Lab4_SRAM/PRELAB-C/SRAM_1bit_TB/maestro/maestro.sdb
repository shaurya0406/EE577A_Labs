ADE simulation setup
Run mode: Single Run, Sweeps and Corners
Tests:
  PRELAB-C_SRAM_1bit_TB_1: PRELAB-C/SRAM_1bit_TB/schematic, simulator spectre
    Outputs: /CLK; /precharge_en; /A<4:0>; /data; /write_en; /decoder_en; /WL<0>; /BL; /BLB; /I0/Q; /I0/QB; /pre_en_SA; /read_en; /sense_en; /data_out; /A_out<4:0>; /I4/OUT; /I4/OUTB; /I4/DATA
