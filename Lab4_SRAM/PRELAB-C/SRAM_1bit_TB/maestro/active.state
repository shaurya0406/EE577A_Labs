ADE simulation setup
Test PRELAB-C_SRAM_1bit_TB_1: PRELAB-C/SRAM_1bit_TB/schematic, simulator spectre
  Models: /home/viterbi/01/ee577/CDS_GPDK45/gpdk045_v_5_0/gpdk045/../models/spectre/gpdk045.scs[mc]
  Temperature: 27
  Files: vectors /home/viterbi/04/shauryac/work_gpdk045/PRELAB-C/SRAM1bit_Test.vec
  Stimulus vdd!: voltage dc dc=1
  Stimulus CLK: voltage pulse dc=1 val0=0 val1=1 period=2n delay=0 rise=5p fall=5p
  Stimulus A_bar<4>: voltage dc dc=1
  Stimulus A_bar<3>: voltage dc dc=1
  Stimulus A_bar<2>: voltage dc dc=1
  Stimulus A_bar<1>: voltage dc dc=1
  Stimulus A_bar<0>: voltage dc dc=1
  Stimulus A<4>: voltage dc dc=0
  Stimulus A<3>: voltage dc dc=0
  Stimulus A<2>: voltage dc dc=0
  Stimulus A<1>: voltage dc dc=0
  Stimulus A<0>: voltage dc dc=0
  Initial conditions: /I4/DATA = 0; /data_out = 0; /I0/QB = 1; /I0/Q = 0
  Analysis tran: stop=24n
  Output /A<1> = VT("/A<1>")
  Output /A<0> = VT("/A<0>")
  Output Col_Addr = awvCreateBus("Col_Addr" list(awvAnalog2Digital(VT("/A<1>") nil nil 0.5 nil "centre") awvAnalog2Digital(VT("/A<0>") nil nil 0.5 nil "centre")) "Binary")
  Signals: /CLK, /precharge_en, /A<4:0>, /data, /write_en, /decoder_en, /WL<0>, /BL, /BLB, /I0/Q, /I0/QB, /pre_en_SA, /read_en, /sense_en, /data_out, /A_out<4:0>, /I4/OUT, /I4/OUTB, /I4/DATA
Run mode: Single Run, Sweeps and Corners
