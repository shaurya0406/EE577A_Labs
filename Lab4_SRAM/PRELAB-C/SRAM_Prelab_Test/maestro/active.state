ADE simulation setup
Test PRELAB-C_SRAM_Prelab_Test_1: PRELAB-C/SRAM_Prelab_Test/schematic, simulator spectre
  Models: /home/viterbi/01/ee577/CDS_GPDK45/gpdk045_v_5_0/gpdk045/../models/spectre/gpdk045.scs[mc]
  Temperature: 27
  Files: vectors /home/viterbi/04/shauryac/work_gpdk045/PRELAB-C/prelab_6t_test.vec
  Stimulus vdd!: voltage dc dc=1
  Analysis tran: stop=105n
  Signals: /WLE as t, /wl_out, /pr_ch, /read_write, /write_data, /WL, /BL, /BLB, /Q, /Qb, /D, /Db
Run mode: Single Run, Sweeps and Corners
