ADE simulation setup
Run mode: Single Run, Sweeps and Corners
Tests:
  PRELAB-C_SRAM_Prelab_Test_1: PRELAB-C/SRAM_Prelab_Test/schematic, simulator spectre
    Outputs: t; /wl_out; /pr_ch; /read_write; /write_data; /Q; /Qb; /D; /Db; /BL; /BLB; /WL
