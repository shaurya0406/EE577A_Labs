ADE simulation setup
Test Lab5_Comparator_FCC_D2_TB_1: Lab5_Comparator/FCC_D2_TB/schematic, simulator spectre
  Models: /home/viterbi/01/ee577/CDS_GPDK45/gpdk045_v_5_0/gpdk045/../models/spectre/gpdk045.scs[mc]
  Temperature: 27
  Files: vectors /home/viterbi/04/shauryac/work_gpdk045/Lab5_Comparator/Vector_Files/FCC_D1_TB.vec
  Stimulus vdd!: voltage dc dc=1
  Analysis tran: stop=16.5n
  Output P_Out_Binary = awvCreateBus("P_Out_Binary" list(awvAnalog2Digital(VT("/P_out<2>") nil nil 0.5 nil "centre") awvAnalog2Digital(VT("/P_out<1>") nil nil 0.5 nil "centre")) "Binary") (unticked)
  Signals: /A, /B, /P<2:1>, /P_out<2:1>
Run mode: Single Run, Sweeps and Corners
