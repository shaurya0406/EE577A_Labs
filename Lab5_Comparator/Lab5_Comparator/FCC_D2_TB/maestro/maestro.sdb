ADE simulation setup
Run mode: Single Run, Sweeps and Corners
Tests:
  Lab5_Comparator_FCC_D2_TB_1: Lab5_Comparator/FCC_D2_TB/schematic, simulator spectre
    Outputs: P_Out_Binary
