ADE simulation setup
Test Lab5_Comparator_FCC_D2_TB_1: Lab5_Comparator/Comp_D2_TB/schematic, simulator spectre
  Models: /home/viterbi/01/ee577/CDS_GPDK45/gpdk045_v_5_0/gpdk045/../models/spectre/gpdk045.scs[mc]
  Temperature: 27
  Stimulus A_in<1>: voltage pulse dc=0 val0=0 val1=1 period=16n
  Stimulus A_in<0>: voltage pulse dc=0 val0=0 val1=1 period=8n
  Stimulus B_in<1>: voltage pulse dc=0 val0=0 val1=1 period=4n
  Stimulus B_in<0>: voltage pulse dc=0 val0=0 val1=1 period=2n
  Stimulus vdd!: voltage dc dc=1
  Analysis tran: stop=16.5n
  Output Ain = awvCreateBus("Ain" list(awvAnalog2Digital(VT("/A_in<1>") nil nil 0.5 nil "centre") awvAnalog2Digital(VT("/A_in<0>") nil nil 0.5 nil "centre")) "Binary")
  Output Bin = awvCreateBus("Bin" list(awvAnalog2Digital(VT("/B_in<1>") nil nil 0.5 nil "centre") awvAnalog2Digital(VT("/B_in<0>") nil nil 0.5 nil "centre")) "Binary")
  Output Oout = awvCreateBus("Oout" list(awvAnalog2Digital(VT("/O_out<1>") nil nil 0.5 nil "centre") awvAnalog2Digital(VT("/O_out<2>") nil nil 0.5 nil "centre")) "Binary")
  Signals: /A_in<1:0>, /B_in<1:0>, /O_out<2:1>
Test Lab5_Comparator_FCC_D3_TB: Lab5_Comparator/Comp_D3_TB/schematic, simulator spectre
  Models: /home/viterbi/01/ee577/CDS_GPDK45/gpdk045_v_5_0/gpdk045/../models/spectre/gpdk045.scs[mc]
  Temperature: 27
  Stimulus A_in<1>: voltage pulse dc=0 val0=0 val1=1 period=16n
  Stimulus A_in<0>: voltage pulse dc=0 val0=0 val1=1 period=8n
  Stimulus B_in<1>: voltage pulse dc=0 val0=0 val1=1 period=4n
  Stimulus B_in<0>: voltage pulse dc=0 val0=0 val1=1 period=2n
  Stimulus vdd!: voltage dc dc=1
  Analysis tran: stop=16.5n
  Output Ain = awvCreateBus("Ain" list(awvAnalog2Digital(VT("/A_in<1>") nil nil 0.5 nil "centre") awvAnalog2Digital(VT("/A_in<0>") nil nil 0.5 nil "centre")) "Binary")
  Output Bin = awvCreateBus("Bin" list(awvAnalog2Digital(VT("/B_in<1>") nil nil 0.5 nil "centre") awvAnalog2Digital(VT("/B_in<0>") nil nil 0.5 nil "centre")) "Binary")
  Output Oout = awvCreateBus("Oout" list(awvAnalog2Digital(VT("/O_out<1>") nil nil 0.5 nil "centre") awvAnalog2Digital(VT("/O_out<2>") nil nil 0.5 nil "centre")) "Binary")
  Signals: /A_in<1:0>, /B_in<1:0>, /O_out<2:1>
