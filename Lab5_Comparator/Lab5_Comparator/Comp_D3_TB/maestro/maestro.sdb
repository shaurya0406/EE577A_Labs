ADE simulation setup
Run mode: Single Run, Sweeps and Corners
Tests:
  Lab5_Comparator_FCC_D3_TB: Lab5_Comparator/Comp_D3_TB/schematic, simulator spectre
    Outputs: Ain; Bin; Oout; "/A<0>"; "/B<0>"; "/HCC0_Out<1>"; /A<0>; /B<0>; /HCC0_Out<1>; /FCC1_Out<1>; "/O_out<1>"; /O_out<1>; /HCC0_Out<2>; /FCC1_Out<2>; /O_out<2>
