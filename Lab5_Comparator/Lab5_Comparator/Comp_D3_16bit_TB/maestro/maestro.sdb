ADE simulation setup
Run mode: Single Run, Sweeps and Corners
Tests:
  Lab5_Comparator_Comp_D3_16bit_TB: Lab5_Comparator/Comp_D3_16bit_TB/schematic, simulator spectre
    Outputs: /Oout<1>; /Oout<2>; /I0/FCC15_IN<2>; /I0/FCC15_IN<1>; "/I0/HCC0_OUT<1>"; /I0/HCC0_OUT<1>; /I0/HCC0_OUT<2>; /I0/FCC1_OUT<1>; /I0/FCC2_OUT<1>; /I0/FCC2_OUT<2>; /I0/FCC1_OUT<2>
