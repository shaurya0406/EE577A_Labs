ADE simulation setup
Run mode: Single Run, Sweeps and Corners
Tests:
  Lab5_Comparator_FCC_D1_TB: Lab5_Comparator/Comp_D1_TB/schematic, simulator spectre
    Outputs: Oout; /A_in<0>; /B_in<0>; /O_out<1>; /HCC0_Out<1>; /FCC1_Out<1>; /HCC0_Out<2>; /FCC1_Out<2>; /O_out<2>
