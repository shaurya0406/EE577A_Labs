ADE simulation setup
Run mode: Single Run, Sweeps and Corners
Tests:
  Lab5_Comparator_FCC_D1_TB: Lab5_Comparator/Comp_D1_TB/schematic, simulator spectre
    Outputs: Ain; Bin; Oout
