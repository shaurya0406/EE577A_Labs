ADE simulation setup
Test Lab5_Comparator_FCC_D2_TB_1: Lab5_Comparator/Comp_D2_TB/schematic, simulator spectre
  Models: /home/viterbi/01/ee577/CDS_GPDK45/gpdk045_v_5_0/gpdk045/../models/spectre/gpdk045.scs[mc]
  Temperature: 27
  Files: vectors /home/viterbi/04/shauryac/work_gpdk045/Lab5_Comparator/Vector_Files/Comp_D3_TB.vec
  Stimulus vdd!: voltage dc dc=1
  Analysis tran: stop=16.5n
  Output Oout = awvCreateBus("Oout" list(awvAnalog2Digital(VT("/O_out<1>") nil nil 0.5 nil "centre") awvAnalog2Digital(VT("/O_out<2>") nil nil 0.5 nil "centre")) "Binary")
  Signals: /A_in<0>, /B_in<0>, /O_out<1>, /HCC0_Out<1>, /FCC1_Out<1>, /HCC0_Out<2>, /FCC1_Out<2>, /O_out<2>
Test Lab5_Comparator_FCC_D1_TB: Lab5_Comparator/Comp_D1_TB/schematic, simulator spectre
  Models: /home/viterbi/01/ee577/CDS_GPDK45/gpdk045_v_5_0/gpdk045/../models/spectre/gpdk045.scs[mc]
  Temperature: 27
  Files: vectors /home/viterbi/04/shauryac/work_gpdk045/Lab5_Comparator/Vector_Files/Comp_D3_TB.vec
  Stimulus vdd!: voltage dc dc=1
  Analysis tran: stop=16.5n
  Output Oout = awvCreateBus("Oout" list(awvAnalog2Digital(VT("/O_out<1>") nil nil 0.5 nil "centre") awvAnalog2Digital(VT("/O_out<2>") nil nil 0.5 nil "centre")) "Binary")
  Signals: /A_in<0>, /B_in<0>, /O_out<1>, /HCC0_Out<1>, /FCC1_Out<1>, /HCC0_Out<2>, /FCC1_Out<2>, /O_out<2>
