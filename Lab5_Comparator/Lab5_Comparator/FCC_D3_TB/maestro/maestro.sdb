ADE simulation setup
Run mode: Single Run, Sweeps and Corners
Tests:
  FCC_D3_TB: Lab5_Comparator/FCC_D3_TB/schematic, simulator spectre
    Outputs: P_Out_Binary
