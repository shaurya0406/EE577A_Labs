ADE simulation setup
Test Lab5_Comparator_Comp_D3_8bit_TB_1: Lab5_Comparator/Comp_D3_8bit_TB/schematic, simulator spectre
  Models: /home/viterbi/01/ee577/CDS_GPDK45/gpdk045_v_5_0/gpdk045/../models/spectre/gpdk045.scs[mc]
  Temperature: 27
  Files: vectors /home/viterbi/04/shauryac/work_gpdk045/Lab5_Comparator/Vector_Files/Comp_8bit_TB.vec
  Stimulus vdd!: voltage dc dc=1
  Stimulus B_in<7>: voltage dc dc=1
  Stimulus B_in<6>: voltage dc dc=1
  Stimulus B_in<5>: voltage dc dc=1
  Stimulus B_in<4>: voltage dc dc=1
  Stimulus B_in<3>: voltage dc dc=1
  Stimulus B_in<2>: voltage dc dc=1
  Stimulus B_in<1>: voltage dc dc=1
  Stimulus A_in<7>: voltage dc dc=1
  Stimulus A_in<6>: voltage dc dc=1
  Stimulus A_in<5>: voltage dc dc=1
  Stimulus A_in<4>: voltage dc dc=1
  Stimulus A_in<3>: voltage dc dc=1
  Stimulus A_in<2>: voltage dc dc=1
  Stimulus A_in<1>: voltage dc dc=1
  Analysis tran: stop=15n
  Signals: /A<0>, /B<0>, /I0/FCC7_IN<2>, /I0/FCC7_IN<1>, /Oout<1>, /Oout<2>
Run mode: Single Run, Sweeps and Corners
