ADE simulation setup
Run mode: Single Run, Sweeps and Corners
Tests:
  Lab5_Comparator_Comp_D3_8bit_TB_1: Lab5_Comparator/Comp_D3_8bit_TB/schematic, simulator spectre
    Outputs: /Oout<1>; /Oout<2>
