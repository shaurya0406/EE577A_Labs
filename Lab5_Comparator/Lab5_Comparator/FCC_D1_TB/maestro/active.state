ADE simulation setup
Test Lab5_Comparator_FCC_D2_TB_1: Lab5_Comparator/FCC_D2_TB/schematic, simulator spectre
  Models: /home/viterbi/01/ee577/CDS_GPDK45/gpdk045_v_5_0/gpdk045/../models/spectre/gpdk045.scs[mc]
  Temperature: 27
  Stimulus vdd!: voltage dc dc=1
  Stimulus A_in: voltage pulse dc=0 val0=0 val1=1 period=16n
  Stimulus B_in: voltage pulse dc=0 val0=0 val1=1 period=8n
  Stimulus P_in<2>: voltage pulse dc=0 val0=0 val1=1 period=2n
  Stimulus P_in<1>: voltage pulse dc=0 val0=0 val1=1 period=4n
  Analysis tran: stop=16.5n
  Output P_Out_Binary = awvCreateBus("P_Out_Binary" list(awvAnalog2Digital(VT("/P_out<2>") nil nil 0.5 nil "centre") awvAnalog2Digital(VT("/P_out<1>") nil nil 0.5 nil "centre")) "Binary")
  Signals: /A, /B, /P<2:1>, /P_out<2:1>
Test Lab5_Comparator_FCC_D1_TB: Lab5_Comparator/FCC_D1_TB/schematic, simulator spectre
  Models: /home/viterbi/01/ee577/CDS_GPDK45/gpdk045_v_5_0/gpdk045/../models/spectre/gpdk045.scs[mc]
  Temperature: 27
  Stimulus A_in: voltage pulse dc=0 val0=0 val1=1 period=16n rise=5p fall=5p
  Stimulus B_in: voltage pulse dc=0 val0=0 val1=1 period=8n rise=5p fall=5p
  Stimulus P_in<2>: voltage pulse dc=0 val0=0 val1=1 period=2n rise=5p fall=5p
  Stimulus P_in<1>: voltage pulse dc=0 val0=0 val1=1 period=4n rise=5p fall=5p
  Stimulus vdd!: voltage dc dc=1
  Analysis tran: stop=16.5n
  Output P_Out_Binary = awvCreateBus("P_Out_Binary" list(awvAnalog2Digital(VT("/P_out<1>") nil nil 0.5 nil "centre") awvAnalog2Digital(VT("/P_out<2>") nil nil 0.5 nil "centre")) "Binary") (unticked)
  Signals: /A, /B, /P<2:1>, /P_out<2:1>
