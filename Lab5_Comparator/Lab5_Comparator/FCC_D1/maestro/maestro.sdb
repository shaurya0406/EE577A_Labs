ADE simulation setup
Run mode: Single Run, Sweeps and Corners
Tests:
  Lab5A_1bit-FCC_design2_1: Lab5A/1bit-FCC_design2/schematic, simulator spectre
