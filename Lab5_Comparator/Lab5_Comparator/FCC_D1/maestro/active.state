ADE simulation setup
Test Lab5A_1bit-FCC_design2_1: Lab5A/1bit-FCC_design2/schematic, simulator spectre
  Models: /home/viterbi/01/ee577/CDS_GPDK45/gpdk045_v_5_0/gpdk045/../models/spectre/gpdk045.scs[mc]
  Temperature: 27
  Stimulus VSS: voltage dc dc=0
  Stimulus VDD: voltage dc dc=1
  Stimulus B: voltage bit val1=1 val0=0 rise=10p fall=10p period=1n data=0000111100001111
  Stimulus A: voltage bit val1=1 val0=0 rise=10p fall=10p period=1n data=0000000011111111
  Stimulus OI<1>: voltage bit val1=1 val0=0 rise=10p fall=10p period=1n data=0011001100110011
  Stimulus OI<2>: voltage bit val1=1 val0=0 rise=10p fall=10p period=1n data=0101010101010101
  Analysis tran: stop=10n
  Output O = awvCreateBus("O" list(awvAnalog2Digital(VT("/O<1>") nil nil 0.5 nil "centre") awvAnalog2Digital(VT("/O<2>") nil nil 0.5 nil "centre")) "Binary")
  Signals: /A, /B, /OI<1>, /OI<2>, /O<1>, /O<2>, /OI1OI2, /ABAR_OI2
Run mode: Single Run, Sweeps and Corners
